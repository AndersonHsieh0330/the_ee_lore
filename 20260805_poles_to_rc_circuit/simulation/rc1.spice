** sch_path: /home/andersonhsieh/repos/projects/the_ee_lore/20260805_poles_to_rc_circuit/rc1.sch
**.subckt rc1
R1 net1 vout 1k m=1
C1 vout GND 1p m=1
V1 net1 GND 0 AC 1
**** begin user architecture code

.control
save all
ac dec 1000 1 10G

write rc1.raw

let vout_db = db(v(vout))
let cutoff_level = vout_db[0] - 3.0102999566
meas ac f_3db when vout_db=$&cutoff_level fall=1

.endc

**** end user architecture code
**.ends
.GLOBAL GND
.end
